* A file a deck includes, its lower resistance
.param lower=3k
